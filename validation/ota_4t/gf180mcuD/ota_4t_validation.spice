**.subckt ota_1stage
XM1 vout net2 vs vs nfet_03v3 W={w_dp}u L={l_dp}u nf={nf_dp}
XM2 net1 vref vs vs nfet_03v3 W={w_dp}u L={l_dp}u nf={nf_dp}
XM3 vout net1 vdd vdd pfet_03v3 W={w_cm}u L={l_cm}u nf={nf_cm}
XM4 net1 net1 vdd vdd pfet_03v3 W={w_cm}u L={l_cm}u nf={nf_cm}
I0 vs GND 20e-6
V1 vdd GND {VDD}
V3 vref GND {VREF}
V4 net2 vfb dc 0 ac 1
C1 vfb GND 10 m=1
R1 vout vfb 100000000 m=1
R2 vfb GND {R2} m=1
**** begin user architecture code

.include {include_model_path}
.lib {corner_model_path} typical

.options temp=25 tnom=25
.control

ac dec 20 1 10G

meas ac dc_gain_db find vdb(vout) at=1
let gain_3db = dc_gain_db-3
meas ac bandwidth_3db_hz when vdb(vout)=gain_3db fall=1
meas ac unity_gain_hz when vdb(vout)=0 fall=1
let phase_deg = phase(vout)*180/PI
meas ac phase_at_unity find phase_deg at=unity_gain_hz
let phase_margin_deg = phase_at_unity

wrdata {ac_results_path} dc_gain_db bandwidth_3db_hz unity_gain_hz phase_margin_deg
.endc

**** end user architecture code
**.ends
.GLOBAL GND
.end
