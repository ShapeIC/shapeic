* Shapeic four-transistor OTA electrical verification.
.lib '{{model_library}}' mos_tt

VDD VDD 0 DC={{vdd_dc}}
VINP VINP 0 DC={{vg_dc}} AC=1
VINN VINN 0 DC={{vg_dc}} AC=0
ITAIL IBIAS 0 DC={{tail_current}}

* Fix the LUT output bias at DC while leaving VOUT practically open in AC.
VOUT_BIAS VOUT_BIAS 0 DC={{vout_dc}} AC=0
LBIAS VOUT_BIAS VOUT {{output_bias_inductance}}

XDP1 VOUT VINP IBIAS IBIAS sg13_lv_nmos l={{length}} w={{width}} ng={{nf}}
XDP2 N1 VINN IBIAS IBIAS sg13_lv_nmos l={{length}} w={{width}} ng={{nf}}
XCM1 VOUT N1 VDD VDD sg13_lv_pmos l={{pmos_length}} w={{pmos_width}} ng={{pmos_nf}}
XCM2 N1 N1 VDD VDD sg13_lv_pmos l={{pmos_length}} w={{pmos_width}} ng={{pmos_nf}}

.options temp=27 tnom=27
.control
pre_osdi {{psp_osdi}}
pre_osdi {{psp_nqs_osdi}}
save v(VOUT) v(IBIAS) v(N1)
op
print v(VOUT) v(IBIAS) v(N1)

ac dec {{ac_points_per_decade}} {{ac_min_hz}} {{ac_max_hz}}
let loop_response = -v(VOUT)
let response_real = real(loop_response)
let response_imag = imag(loop_response)
let gain_db = vdb(loop_response)
let phase_deg = 180 / pi * cph(loop_response)
meas ac dc_gain_db find gain_db at={{ac_min_hz}}
let gain_3db = dc_gain_db - 3
meas ac bandwidth_3db_hz when gain_db=gain_3db fall=1
{{optional_ac_measurements}}

option numdgt=15
set wr_vecnames
set wr_singlescale
wrdata ngspice_ac.tsv response_real response_imag gain_db phase_deg

* Measurements are scalar vectors but inherit the AC scale; replace it with one point.
compose result_index values 0
setscale result_index
wrdata {{results_path}} dc_gain_db bandwidth_3db_hz{{optional_result_vectors}}
.endc
.end
