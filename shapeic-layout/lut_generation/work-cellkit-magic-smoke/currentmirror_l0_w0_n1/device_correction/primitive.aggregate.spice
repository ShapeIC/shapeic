.subckt aggregate_currentmirror DOUT DREF S B
XM1 DOUT DREF S B sg13_lv_pmos l=3.99999999999999982e-07 w=7.49999999999999934e-06 ng=50
XM2 DREF DREF S B sg13_lv_pmos l=3.99999999999999982e-07 w=7.49999999999999934e-06 ng=50
.ends aggregate_currentmirror
