.subckt currentmirror_l0p400_wf0p150_nf50_flat DOUT DREF S B
X0 DOUT DREF S B sg13_lv_pmos ad=55.5f pd=0.74u as=55.5f ps=0.74u w=0.15u l=0.4u
X1 S S S B sg13_lv_pmos ad=55.5f pd=0.74u as=0.14121n ps=1.03754m w=0.15u l=0.4u
X2 S DREF DREF B sg13_lv_pmos ad=55.5f pd=0.74u as=55.5f ps=0.74u w=0.15u l=0.4u
X3 S S S B sg13_lv_pmos ad=55.5f pd=0.74u as=0 ps=0 w=0.15u l=0.4u
X4 S S S B sg13_lv_pmos ad=55.5f pd=0.74u as=0 ps=0 w=0.15u l=0.4u
X5 S DREF DOUT B sg13_lv_pmos ad=55.5f pd=0.74u as=55.5f ps=0.74u w=0.15u l=0.4u
X6 S S S B sg13_lv_pmos ad=55.5f pd=0.74u as=0 ps=0 w=0.15u l=0.4u
X7 DREF DREF S B sg13_lv_pmos ad=55.5f pd=0.74u as=55.5f ps=0.74u w=0.15u l=0.4u
X8 S S S B sg13_lv_pmos ad=55.5f pd=0.74u as=0 ps=0 w=0.15u l=0.4u
X9 S S S B sg13_lv_pmos ad=55.5f pd=0.74u as=0 ps=0 w=0.15u l=0.4u
X10 S DREF DREF B sg13_lv_pmos ad=55.5f pd=0.74u as=55.5f ps=0.74u w=0.15u l=0.4u
X11 S S S B sg13_lv_pmos ad=55.5f pd=0.74u as=0 ps=0 w=0.15u l=0.4u
X12 DOUT DREF S B sg13_lv_pmos ad=55.5f pd=0.74u as=55.5f ps=0.74u w=0.15u l=0.4u
X13 S S S B sg13_lv_pmos ad=55.5f pd=0.74u as=0 ps=0 w=0.15u l=0.4u
X14 S DREF DREF B sg13_lv_pmos ad=55.5f pd=0.74u as=55.5f ps=0.74u w=0.15u l=0.4u
X15 S S S B sg13_lv_pmos ad=55.5f pd=0.74u as=0 ps=0 w=0.15u l=0.4u
X16 S S S B sg13_lv_pmos ad=55.5f pd=0.74u as=0 ps=0 w=0.15u l=0.4u
X17 DREF DREF S B sg13_lv_pmos ad=55.5f pd=0.74u as=55.5f ps=0.74u w=0.15u l=0.4u
X18 S S S B sg13_lv_pmos ad=55.5f pd=0.74u as=0 ps=0 w=0.15u l=0.4u
X19 S DREF DREF B sg13_lv_pmos ad=55.5f pd=0.74u as=55.5f ps=0.74u w=0.15u l=0.4u
X20 S S S B sg13_lv_pmos ad=55.5f pd=0.74u as=0 ps=0 w=0.15u l=0.4u
X21 DREF DREF S B sg13_lv_pmos ad=55.5f pd=0.74u as=55.5f ps=0.74u w=0.15u l=0.4u
X22 DOUT DREF S B sg13_lv_pmos ad=55.5f pd=0.74u as=55.5f ps=0.74u w=0.15u l=0.4u
X23 S DREF DREF B sg13_lv_pmos ad=55.5f pd=0.74u as=55.5f ps=0.74u w=0.15u l=0.4u
X24 S S S B sg13_lv_pmos ad=55.5f pd=0.74u as=0 ps=0 w=0.15u l=0.4u
X25 S S S B sg13_lv_pmos ad=55.5f pd=0.74u as=0 ps=0 w=0.15u l=0.4u
X26 S S S B sg13_lv_pmos ad=55.5f pd=0.74u as=0 ps=0 w=0.15u l=0.4u
X27 S DREF DOUT B sg13_lv_pmos ad=55.5f pd=0.74u as=55.5f ps=0.74u w=0.15u l=0.4u
X28 DREF DREF S B sg13_lv_pmos ad=55.5f pd=0.74u as=55.5f ps=0.74u w=0.15u l=0.4u
X29 DREF DREF S B sg13_lv_pmos ad=55.5f pd=0.74u as=55.5f ps=0.74u w=0.15u l=0.4u
X30 S S S B sg13_lv_pmos ad=55.5f pd=0.74u as=0 ps=0 w=0.15u l=0.4u
X31 S S S B sg13_lv_pmos ad=55.5f pd=0.74u as=0 ps=0 w=0.15u l=0.4u
X32 S DREF DREF B sg13_lv_pmos ad=55.5f pd=0.74u as=55.5f ps=0.74u w=0.15u l=0.4u
X33 S DREF DREF B sg13_lv_pmos ad=55.5f pd=0.74u as=55.5f ps=0.74u w=0.15u l=0.4u
X34 DOUT DREF S B sg13_lv_pmos ad=55.5f pd=0.74u as=55.5f ps=0.74u w=0.15u l=0.4u
X35 DREF DREF S B sg13_lv_pmos ad=55.5f pd=0.74u as=55.5f ps=0.74u w=0.15u l=0.4u
X36 S DREF DOUT B sg13_lv_pmos ad=55.5f pd=0.74u as=55.5f ps=0.74u w=0.15u l=0.4u
X37 S DREF DOUT B sg13_lv_pmos ad=55.5f pd=0.74u as=55.5f ps=0.74u w=0.15u l=0.4u
X38 S S S B sg13_lv_pmos ad=0.1005p pd=1.34u as=0 ps=0 w=0.15u l=0.4u
X39 S DREF DREF B sg13_lv_pmos ad=55.5f pd=0.74u as=55.5f ps=0.74u w=0.15u l=0.4u
X40 DOUT DREF S B sg13_lv_pmos ad=55.5f pd=0.74u as=55.5f ps=0.74u w=0.15u l=0.4u
X41 S S S B sg13_lv_pmos ad=55.5f pd=0.74u as=0 ps=0 w=0.15u l=0.4u
X42 DOUT DREF S B sg13_lv_pmos ad=55.5f pd=0.74u as=55.5f ps=0.74u w=0.15u l=0.4u
X43 DREF DREF S B sg13_lv_pmos ad=55.5f pd=0.74u as=0.1005p ps=1.34u w=0.15u l=0.4u
X44 DOUT DREF S B sg13_lv_pmos ad=55.5f pd=0.74u as=55.5f ps=0.74u w=0.15u l=0.4u
X45 S S S B sg13_lv_pmos ad=55.5f pd=0.74u as=0 ps=0 w=0.15u l=0.4u
X46 DOUT DREF S B sg13_lv_pmos ad=55.5f pd=0.74u as=55.5f ps=0.74u w=0.15u l=0.4u
X47 S DREF DOUT B sg13_lv_pmos ad=55.5f pd=0.74u as=55.5f ps=0.74u w=0.15u l=0.4u
X48 S DREF DOUT B sg13_lv_pmos ad=55.5f pd=0.74u as=55.5f ps=0.74u w=0.15u l=0.4u
X49 S DREF DREF B sg13_lv_pmos ad=55.5f pd=0.74u as=55.5f ps=0.74u w=0.15u l=0.4u
X50 DREF DREF S B sg13_lv_pmos ad=55.5f pd=0.74u as=55.5f ps=0.74u w=0.15u l=0.4u
X51 S S S B sg13_lv_pmos ad=55.5f pd=0.74u as=0 ps=0 w=0.15u l=0.4u
X52 S S S B sg13_lv_pmos ad=55.5f pd=0.74u as=0 ps=0 w=0.15u l=0.4u
X53 DOUT DREF S B sg13_lv_pmos ad=55.5f pd=0.74u as=55.5f ps=0.74u w=0.15u l=0.4u
X54 S DREF DREF B sg13_lv_pmos ad=55.5f pd=0.74u as=55.5f ps=0.74u w=0.15u l=0.4u
X55 DREF DREF S B sg13_lv_pmos ad=55.5f pd=0.74u as=55.5f ps=0.74u w=0.15u l=0.4u
X56 S S S B sg13_lv_pmos ad=55.5f pd=0.74u as=0 ps=0 w=0.15u l=0.4u
X57 S S S B sg13_lv_pmos ad=55.5f pd=0.74u as=0 ps=0 w=0.15u l=0.4u
X58 S S S B sg13_lv_pmos ad=55.5f pd=0.74u as=0 ps=0 w=0.15u l=0.4u
X59 S DREF DOUT B sg13_lv_pmos ad=55.5f pd=0.74u as=55.5f ps=0.74u w=0.15u l=0.4u
X60 DOUT DREF S B sg13_lv_pmos ad=55.5f pd=0.74u as=55.5f ps=0.74u w=0.15u l=0.4u
X61 DREF DREF S B sg13_lv_pmos ad=55.5f pd=0.74u as=55.5f ps=0.74u w=0.15u l=0.4u
X62 S DREF DREF B sg13_lv_pmos ad=55.5f pd=0.74u as=55.5f ps=0.74u w=0.15u l=0.4u
X63 S DREF DREF B sg13_lv_pmos ad=55.5f pd=0.74u as=55.5f ps=0.74u w=0.15u l=0.4u
X64 S S S B sg13_lv_pmos ad=55.5f pd=0.74u as=0 ps=0 w=0.15u l=0.4u
X65 S DREF DOUT B sg13_lv_pmos ad=55.5f pd=0.74u as=55.5f ps=0.74u w=0.15u l=0.4u
X66 DOUT DREF S B sg13_lv_pmos ad=55.5f pd=0.74u as=55.5f ps=0.74u w=0.15u l=0.4u
X67 S S S B sg13_lv_pmos ad=55.5f pd=0.74u as=0 ps=0 w=0.15u l=0.4u
X68 S DREF DOUT B sg13_lv_pmos ad=55.5f pd=0.74u as=55.5f ps=0.74u w=0.15u l=0.4u
X69 DREF DREF S B sg13_lv_pmos ad=55.5f pd=0.74u as=55.5f ps=0.74u w=0.15u l=0.4u
X70 DOUT DREF S B sg13_lv_pmos ad=55.5f pd=0.74u as=55.5f ps=0.74u w=0.15u l=0.4u
X71 S DREF DOUT B sg13_lv_pmos ad=55.5f pd=0.74u as=55.5f ps=0.74u w=0.15u l=0.4u
X72 S DREF DOUT B sg13_lv_pmos ad=55.5f pd=0.74u as=55.5f ps=0.74u w=0.15u l=0.4u
X73 S S S B sg13_lv_pmos ad=55.5f pd=0.74u as=0 ps=0 w=0.15u l=0.4u
X74 S S S B sg13_lv_pmos ad=55.5f pd=0.74u as=0 ps=0 w=0.15u l=0.4u
X75 S S S B sg13_lv_pmos ad=55.5f pd=0.74u as=0 ps=0 w=0.15u l=0.4u
X76 S S S B sg13_lv_pmos ad=55.5f pd=0.74u as=0 ps=0 w=0.15u l=0.4u
X77 S DREF DOUT B sg13_lv_pmos ad=55.5f pd=0.74u as=55.5f ps=0.74u w=0.15u l=0.4u
X78 DOUT DREF S B sg13_lv_pmos ad=55.5f pd=0.74u as=55.5f ps=0.74u w=0.15u l=0.4u
X79 S DREF DREF B sg13_lv_pmos ad=55.5f pd=0.74u as=55.5f ps=0.74u w=0.15u l=0.4u
X80 S S S B sg13_lv_pmos ad=55.5f pd=0.74u as=0 ps=0 w=0.15u l=0.4u
X81 S S S B sg13_lv_pmos ad=55.5f pd=0.74u as=0 ps=0 w=0.15u l=0.4u
X82 DREF DREF S B sg13_lv_pmos ad=55.5f pd=0.74u as=55.5f ps=0.74u w=0.15u l=0.4u
X83 DREF DREF S B sg13_lv_pmos ad=55.5f pd=0.74u as=55.5f ps=0.74u w=0.15u l=0.4u
X84 S S S B sg13_lv_pmos ad=55.5f pd=0.74u as=0 ps=0 w=0.15u l=0.4u
X85 S DREF DOUT B sg13_lv_pmos ad=55.5f pd=0.74u as=55.5f ps=0.74u w=0.15u l=0.4u
X86 S S S B sg13_lv_pmos ad=55.5f pd=0.74u as=0 ps=0 w=0.15u l=0.4u
X87 DOUT DREF S B sg13_lv_pmos ad=55.5f pd=0.74u as=55.5f ps=0.74u w=0.15u l=0.4u
X88 S S S B sg13_lv_pmos ad=55.5f pd=0.74u as=0 ps=0 w=0.15u l=0.4u
X89 S S S B sg13_lv_pmos ad=55.5f pd=0.74u as=0 ps=0 w=0.15u l=0.4u
X90 S S S B sg13_lv_pmos ad=55.5f pd=0.74u as=0 ps=0 w=0.15u l=0.4u
X91 S DREF DREF B sg13_lv_pmos ad=55.5f pd=0.74u as=55.5f ps=0.74u w=0.15u l=0.4u
X92 S DREF DREF B sg13_lv_pmos ad=55.5f pd=0.74u as=55.5f ps=0.74u w=0.15u l=0.4u
X93 S S S B sg13_lv_pmos ad=55.5f pd=0.74u as=0 ps=0 w=0.15u l=0.4u
X94 DOUT DREF S B sg13_lv_pmos ad=55.5f pd=0.74u as=55.5f ps=0.74u w=0.15u l=0.4u
X95 S DREF DOUT B sg13_lv_pmos ad=55.5f pd=0.74u as=55.5f ps=0.74u w=0.15u l=0.4u
X96 DREF DREF S B sg13_lv_pmos ad=55.5f pd=0.74u as=55.5f ps=0.74u w=0.15u l=0.4u
X97 S DREF DOUT B sg13_lv_pmos ad=0.1005p pd=1.34u as=55.5f ps=0.74u w=0.15u l=0.4u
X98 S S S B sg13_lv_pmos ad=55.5f pd=0.74u as=0 ps=0 w=0.15u l=0.4u
X99 S S S B sg13_lv_pmos ad=55.5f pd=0.74u as=0 ps=0 w=0.15u l=0.4u
X100 DREF DREF S B sg13_lv_pmos ad=55.5f pd=0.74u as=55.5f ps=0.74u w=0.15u l=0.4u
X101 S S S B sg13_lv_pmos ad=55.5f pd=0.74u as=0 ps=0 w=0.15u l=0.4u
X102 DOUT DREF S B sg13_lv_pmos ad=55.5f pd=0.74u as=55.5f ps=0.74u w=0.15u l=0.4u
X103 S DREF DREF B sg13_lv_pmos ad=55.5f pd=0.74u as=55.5f ps=0.74u w=0.15u l=0.4u
X104 S S S B sg13_lv_pmos ad=55.5f pd=0.74u as=0 ps=0 w=0.15u l=0.4u
X105 DOUT DREF S B sg13_lv_pmos ad=55.5f pd=0.74u as=55.5f ps=0.74u w=0.15u l=0.4u
X106 S S S B sg13_lv_pmos ad=55.5f pd=0.74u as=0 ps=0 w=0.15u l=0.4u
X107 S S S B sg13_lv_pmos ad=0.1005p pd=1.34u as=0 ps=0 w=0.15u l=0.4u
X108 S DREF DREF B sg13_lv_pmos ad=55.5f pd=0.74u as=55.5f ps=0.74u w=0.15u l=0.4u
X109 S S S B sg13_lv_pmos ad=55.5f pd=0.74u as=0 ps=0 w=0.15u l=0.4u
X110 DREF DREF S B sg13_lv_pmos ad=55.5f pd=0.74u as=55.5f ps=0.74u w=0.15u l=0.4u
X111 S S S B sg13_lv_pmos ad=55.5f pd=0.74u as=0 ps=0 w=0.15u l=0.4u
X112 S S S B sg13_lv_pmos ad=55.5f pd=0.74u as=0 ps=0 w=0.15u l=0.4u
X113 S DREF DOUT B sg13_lv_pmos ad=55.5f pd=0.74u as=55.5f ps=0.74u w=0.15u l=0.4u
X114 S S S B sg13_lv_pmos ad=55.5f pd=0.74u as=0 ps=0 w=0.15u l=0.4u
X115 S S S B sg13_lv_pmos ad=55.5f pd=0.74u as=0 ps=0 w=0.15u l=0.4u
X116 DREF DREF S B sg13_lv_pmos ad=55.5f pd=0.74u as=55.5f ps=0.74u w=0.15u l=0.4u
X117 DREF DREF S B sg13_lv_pmos ad=55.5f pd=0.74u as=55.5f ps=0.74u w=0.15u l=0.4u
X118 S S S B sg13_lv_pmos ad=55.5f pd=0.74u as=0 ps=0 w=0.15u l=0.4u
X119 S DREF DREF B sg13_lv_pmos ad=55.5f pd=0.74u as=55.5f ps=0.74u w=0.15u l=0.4u
X120 DOUT DREF S B sg13_lv_pmos ad=55.5f pd=0.74u as=55.5f ps=0.74u w=0.15u l=0.4u
X121 S S S B sg13_lv_pmos ad=55.5f pd=0.74u as=0 ps=0 w=0.15u l=0.4u
X122 S S S B sg13_lv_pmos ad=55.5f pd=0.74u as=0 ps=0 w=0.15u l=0.4u
X123 S S S B sg13_lv_pmos ad=55.5f pd=0.74u as=0 ps=0 w=0.15u l=0.4u
X124 S S S B sg13_lv_pmos ad=55.5f pd=0.74u as=0 ps=0 w=0.15u l=0.4u
X125 S DREF DREF B sg13_lv_pmos ad=55.5f pd=0.74u as=55.5f ps=0.74u w=0.15u l=0.4u
X126 S S S B sg13_lv_pmos ad=55.5f pd=0.74u as=0 ps=0 w=0.15u l=0.4u
X127 DREF DREF S B sg13_lv_pmos ad=55.5f pd=0.74u as=55.5f ps=0.74u w=0.15u l=0.4u
X128 S DREF DOUT B sg13_lv_pmos ad=55.5f pd=0.74u as=55.5f ps=0.74u w=0.15u l=0.4u
X129 S S S B sg13_lv_pmos ad=55.5f pd=0.74u as=0 ps=0 w=0.15u l=0.4u
X130 S S S B sg13_lv_pmos ad=55.5f pd=0.74u as=0 ps=0 w=0.15u l=0.4u
X131 S S S B sg13_lv_pmos ad=55.5f pd=0.74u as=0 ps=0 w=0.15u l=0.4u
X132 S S S B sg13_lv_pmos ad=55.5f pd=0.74u as=0 ps=0 w=0.15u l=0.4u
X133 S S S B sg13_lv_pmos ad=55.5f pd=0.74u as=0 ps=0 w=0.15u l=0.4u
X134 S S S B sg13_lv_pmos ad=55.5f pd=0.74u as=0 ps=0 w=0.15u l=0.4u
X135 S S S B sg13_lv_pmos ad=55.5f pd=0.74u as=0 ps=0 w=0.15u l=0.4u
X136 S S S B sg13_lv_pmos ad=55.5f pd=0.74u as=0 ps=0 w=0.15u l=0.4u
X137 S DREF DREF B sg13_lv_pmos ad=55.5f pd=0.74u as=55.5f ps=0.74u w=0.15u l=0.4u
X138 S S S B sg13_lv_pmos ad=55.5f pd=0.74u as=0 ps=0 w=0.15u l=0.4u
X139 S S S B sg13_lv_pmos ad=55.5f pd=0.74u as=0 ps=0 w=0.15u l=0.4u
X140 S S S B sg13_lv_pmos ad=55.5f pd=0.74u as=0 ps=0 w=0.15u l=0.4u
X141 DREF DREF S B sg13_lv_pmos ad=55.5f pd=0.74u as=55.5f ps=0.74u w=0.15u l=0.4u
X142 S S S B sg13_lv_pmos ad=55.5f pd=0.74u as=0 ps=0 w=0.15u l=0.4u
X143 S S S B sg13_lv_pmos ad=55.5f pd=0.74u as=0 ps=0 w=0.15u l=0.4u
X144 S S S B sg13_lv_pmos ad=55.5f pd=0.74u as=0 ps=0 w=0.15u l=0.4u
X145 S DREF DREF B sg13_lv_pmos ad=55.5f pd=0.74u as=55.5f ps=0.74u w=0.15u l=0.4u
X146 S S S B sg13_lv_pmos ad=55.5f pd=0.74u as=0 ps=0 w=0.15u l=0.4u
X147 S S S B sg13_lv_pmos ad=55.5f pd=0.74u as=0 ps=0 w=0.15u l=0.4u
X148 S S S B sg13_lv_pmos ad=55.5f pd=0.74u as=0 ps=0 w=0.15u l=0.4u
X149 S S S B sg13_lv_pmos ad=55.5f pd=0.74u as=0 ps=0 w=0.15u l=0.4u
X150 S S S B sg13_lv_pmos ad=55.5f pd=0.74u as=0 ps=0 w=0.15u l=0.4u
X151 DREF DREF S B sg13_lv_pmos ad=55.5f pd=0.74u as=55.5f ps=0.74u w=0.15u l=0.4u
X152 S S S B sg13_lv_pmos ad=55.5f pd=0.74u as=0 ps=0 w=0.15u l=0.4u
X153 S S S B sg13_lv_pmos ad=55.5f pd=0.74u as=0 ps=0 w=0.15u l=0.4u
X154 S S S B sg13_lv_pmos ad=55.5f pd=0.74u as=0 ps=0 w=0.15u l=0.4u
X155 S S S B sg13_lv_pmos ad=55.5f pd=0.74u as=0 ps=0 w=0.15u l=0.4u
X156 DOUT DREF S B sg13_lv_pmos ad=55.5f pd=0.74u as=0.1005p ps=1.34u w=0.15u l=0.4u
X157 S S S B sg13_lv_pmos ad=55.5f pd=0.74u as=0 ps=0 w=0.15u l=0.4u
X158 S S S B sg13_lv_pmos ad=55.5f pd=0.74u as=0 ps=0 w=0.15u l=0.4u
X159 DREF DREF S B sg13_lv_pmos ad=55.5f pd=0.74u as=55.5f ps=0.74u w=0.15u l=0.4u
X160 S S S B sg13_lv_pmos ad=55.5f pd=0.74u as=0 ps=0 w=0.15u l=0.4u
X161 S S S B sg13_lv_pmos ad=55.5f pd=0.74u as=0 ps=0 w=0.15u l=0.4u
X162 S S S B sg13_lv_pmos ad=55.5f pd=0.74u as=0 ps=0 w=0.15u l=0.4u
X163 S S S B sg13_lv_pmos ad=55.5f pd=0.74u as=0 ps=0 w=0.15u l=0.4u
X164 S S S B sg13_lv_pmos ad=55.5f pd=0.74u as=0 ps=0 w=0.15u l=0.4u
X165 S DREF DOUT B sg13_lv_pmos ad=55.5f pd=0.74u as=55.5f ps=0.74u w=0.15u l=0.4u
X166 S S S B sg13_lv_pmos ad=55.5f pd=0.74u as=0 ps=0 w=0.15u l=0.4u
X167 S S S B sg13_lv_pmos ad=55.5f pd=0.74u as=0 ps=0 w=0.15u l=0.4u
X168 DOUT DREF S B sg13_lv_pmos ad=55.5f pd=0.74u as=55.5f ps=0.74u w=0.15u l=0.4u
X169 DOUT DREF S B sg13_lv_pmos ad=55.5f pd=0.74u as=55.5f ps=0.74u w=0.15u l=0.4u
X170 S S S B sg13_lv_pmos ad=55.5f pd=0.74u as=0 ps=0 w=0.15u l=0.4u
X171 S DREF DOUT B sg13_lv_pmos ad=55.5f pd=0.74u as=55.5f ps=0.74u w=0.15u l=0.4u
X172 DOUT DREF S B sg13_lv_pmos ad=55.5f pd=0.74u as=55.5f ps=0.74u w=0.15u l=0.4u
X173 S S S B sg13_lv_pmos ad=55.5f pd=0.74u as=0 ps=0 w=0.15u l=0.4u
X174 S DREF DOUT B sg13_lv_pmos ad=55.5f pd=0.74u as=55.5f ps=0.74u w=0.15u l=0.4u
X175 DOUT DREF S B sg13_lv_pmos ad=55.5f pd=0.74u as=55.5f ps=0.74u w=0.15u l=0.4u
X176 S S S B sg13_lv_pmos ad=55.5f pd=0.74u as=0 ps=0 w=0.15u l=0.4u
X177 S S S B sg13_lv_pmos ad=55.5f pd=0.74u as=0 ps=0 w=0.15u l=0.4u
X178 S DREF DOUT B sg13_lv_pmos ad=55.5f pd=0.74u as=55.5f ps=0.74u w=0.15u l=0.4u
X179 S DREF DREF B sg13_lv_pmos ad=0.1005p pd=1.34u as=55.5f ps=0.74u w=0.15u l=0.4u
X180 S DREF DREF B sg13_lv_pmos ad=55.5f pd=0.74u as=55.5f ps=0.74u w=0.15u l=0.4u
X181 S S S B sg13_lv_pmos ad=55.5f pd=0.74u as=0 ps=0 w=0.15u l=0.4u
X182 S S S B sg13_lv_pmos ad=55.5f pd=0.74u as=0 ps=0 w=0.15u l=0.4u
X183 S DREF DOUT B sg13_lv_pmos ad=55.5f pd=0.74u as=55.5f ps=0.74u w=0.15u l=0.4u
X184 DREF DREF S B sg13_lv_pmos ad=55.5f pd=0.74u as=55.5f ps=0.74u w=0.15u l=0.4u
X185 DOUT DREF S B sg13_lv_pmos ad=55.5f pd=0.74u as=55.5f ps=0.74u w=0.15u l=0.4u
X186 S DREF DREF B sg13_lv_pmos ad=55.5f pd=0.74u as=55.5f ps=0.74u w=0.15u l=0.4u
X187 S S S B sg13_lv_pmos ad=55.5f pd=0.74u as=0 ps=0 w=0.15u l=0.4u
X188 DOUT DREF S B sg13_lv_pmos ad=55.5f pd=0.74u as=55.5f ps=0.74u w=0.15u l=0.4u
X189 S DREF DREF B sg13_lv_pmos ad=55.5f pd=0.74u as=55.5f ps=0.74u w=0.15u l=0.4u
X190 S DREF DOUT B sg13_lv_pmos ad=55.5f pd=0.74u as=55.5f ps=0.74u w=0.15u l=0.4u
X191 S S S B sg13_lv_pmos ad=55.5f pd=0.74u as=0 ps=0 w=0.15u l=0.4u
X192 S S S B sg13_lv_pmos ad=55.5f pd=0.74u as=0 ps=0 w=0.15u l=0.4u
X193 S S S B sg13_lv_pmos ad=55.5f pd=0.74u as=0 ps=0 w=0.15u l=0.4u
X194 S S S B sg13_lv_pmos ad=55.5f pd=0.74u as=0 ps=0 w=0.15u l=0.4u
X195 S DREF DOUT B sg13_lv_pmos ad=55.5f pd=0.74u as=55.5f ps=0.74u w=0.15u l=0.4u
X196 S S S B sg13_lv_pmos ad=55.5f pd=0.74u as=0 ps=0 w=0.15u l=0.4u
X197 DREF DREF S B sg13_lv_pmos ad=55.5f pd=0.74u as=55.5f ps=0.74u w=0.15u l=0.4u
X198 S DREF DOUT B sg13_lv_pmos ad=55.5f pd=0.74u as=55.5f ps=0.74u w=0.15u l=0.4u
X199 DREF DREF S B sg13_lv_pmos ad=55.5f pd=0.74u as=55.5f ps=0.74u w=0.15u l=0.4u
.ends currentmirror_l0p400_wf0p150_nf50_flat
