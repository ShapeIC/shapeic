.subckt currentmirror_l0p400_wf0p150_nf1_flat DOUT DREF S B
X0 DOUT DREF S B sg13_lv_pmos ad=0.1005p pd=1.34u as=0.1005p ps=1.34u w=0.15u l=0.4u
X1 DREF DREF S B sg13_lv_pmos ad=0.1005p pd=1.34u as=0.1005p ps=1.34u w=0.15u l=0.4u
X2 S S S B sg13_lv_pmos ad=0.1005p pd=1.34u as=8.2134p ps=57.54u w=0.15u l=0.4u
X3 S S S B sg13_lv_pmos ad=0.1005p pd=1.34u as=0 ps=0 w=0.15u l=0.4u
.ends currentmirror_l0p400_wf0p150_nf1_flat
