.subckt aggregate_simplediffpair DP DN GP GN S B
XM1 DP GP S B sg13_lv_nmos l=3.99999999999999982e-07 w=7.49999999999999934e-06 ng=50
XM2 DN GN S B sg13_lv_nmos l=3.99999999999999982e-07 w=7.49999999999999934e-06 ng=50
.ends aggregate_simplediffpair
