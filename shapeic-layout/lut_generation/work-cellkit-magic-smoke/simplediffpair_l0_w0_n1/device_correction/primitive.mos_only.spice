.subckt simplediffpair_l0p400_wf0p150_nf50_flat DP DN GP GN S B
X0 S S S B sg13_lv_nmos ad=55.5f pd=0.74u as=0.1428n ps=1.06276m w=0.15u l=0.4u
X1 S GN DN B sg13_lv_nmos ad=55.5f pd=0.74u as=55.5f ps=0.74u w=0.15u l=0.4u
X2 S S S B sg13_lv_nmos ad=55.5f pd=0.74u as=0 ps=0 w=0.15u l=0.4u
X3 S S S B sg13_lv_nmos ad=55.5f pd=0.74u as=0 ps=0 w=0.15u l=0.4u
X4 DN GN S B sg13_lv_nmos ad=55.5f pd=0.74u as=55.5f ps=0.74u w=0.15u l=0.4u
X5 S S S B sg13_lv_nmos ad=55.5f pd=0.74u as=0 ps=0 w=0.15u l=0.4u
X6 S GP DP B sg13_lv_nmos ad=55.5f pd=0.74u as=55.5f ps=0.74u w=0.15u l=0.4u
X7 S S S B sg13_lv_nmos ad=55.5f pd=0.74u as=0 ps=0 w=0.15u l=0.4u
X8 S S S B sg13_lv_nmos ad=55.5f pd=0.74u as=0 ps=0 w=0.15u l=0.4u
X9 DP GP S B sg13_lv_nmos ad=55.5f pd=0.74u as=55.5f ps=0.74u w=0.15u l=0.4u
X10 S GN DN B sg13_lv_nmos ad=55.5f pd=0.74u as=55.5f ps=0.74u w=0.15u l=0.4u
X11 DN GN S B sg13_lv_nmos ad=55.5f pd=0.74u as=55.5f ps=0.74u w=0.15u l=0.4u
X12 S GP DP B sg13_lv_nmos ad=55.5f pd=0.74u as=55.5f ps=0.74u w=0.15u l=0.4u
X13 S S S B sg13_lv_nmos ad=0.1005p pd=1.34u as=0 ps=0 w=0.15u l=0.4u
X14 DN GN S B sg13_lv_nmos ad=55.5f pd=0.74u as=55.5f ps=0.74u w=0.15u l=0.4u
X15 S S S B sg13_lv_nmos ad=55.5f pd=0.74u as=0 ps=0 w=0.15u l=0.4u
X16 S GN DN B sg13_lv_nmos ad=55.5f pd=0.74u as=55.5f ps=0.74u w=0.15u l=0.4u
X17 S S S B sg13_lv_nmos ad=55.5f pd=0.74u as=0 ps=0 w=0.15u l=0.4u
X18 S GP DP B sg13_lv_nmos ad=55.5f pd=0.74u as=55.5f ps=0.74u w=0.15u l=0.4u
X19 DN GN S B sg13_lv_nmos ad=55.5f pd=0.74u as=55.5f ps=0.74u w=0.15u l=0.4u
X20 S GN DN B sg13_lv_nmos ad=55.5f pd=0.74u as=55.5f ps=0.74u w=0.15u l=0.4u
X21 S GP DP B sg13_lv_nmos ad=55.5f pd=0.74u as=55.5f ps=0.74u w=0.15u l=0.4u
X22 S S S B sg13_lv_nmos ad=55.5f pd=0.74u as=0 ps=0 w=0.15u l=0.4u
X23 S GP DP B sg13_lv_nmos ad=55.5f pd=0.74u as=55.5f ps=0.74u w=0.15u l=0.4u
X24 DN GN S B sg13_lv_nmos ad=55.5f pd=0.74u as=55.5f ps=0.74u w=0.15u l=0.4u
X25 S S S B sg13_lv_nmos ad=55.5f pd=0.74u as=0 ps=0 w=0.15u l=0.4u
X26 DP GP S B sg13_lv_nmos ad=55.5f pd=0.74u as=55.5f ps=0.74u w=0.15u l=0.4u
X27 S S S B sg13_lv_nmos ad=55.5f pd=0.74u as=0 ps=0 w=0.15u l=0.4u
X28 S GN DN B sg13_lv_nmos ad=55.5f pd=0.74u as=55.5f ps=0.74u w=0.15u l=0.4u
X29 S S S B sg13_lv_nmos ad=55.5f pd=0.74u as=0 ps=0 w=0.15u l=0.4u
X30 DP GP S B sg13_lv_nmos ad=55.5f pd=0.74u as=55.5f ps=0.74u w=0.15u l=0.4u
X31 DN GN S B sg13_lv_nmos ad=55.5f pd=0.74u as=0.1005p ps=1.34u w=0.15u l=0.4u
X32 S S S B sg13_lv_nmos ad=55.5f pd=0.74u as=0 ps=0 w=0.15u l=0.4u
X33 S GN DN B sg13_lv_nmos ad=55.5f pd=0.74u as=55.5f ps=0.74u w=0.15u l=0.4u
X34 DN GN S B sg13_lv_nmos ad=55.5f pd=0.74u as=55.5f ps=0.74u w=0.15u l=0.4u
X35 S GP DP B sg13_lv_nmos ad=55.5f pd=0.74u as=55.5f ps=0.74u w=0.15u l=0.4u
X36 S S S B sg13_lv_nmos ad=55.5f pd=0.74u as=0 ps=0 w=0.15u l=0.4u
X37 S GP DP B sg13_lv_nmos ad=55.5f pd=0.74u as=55.5f ps=0.74u w=0.15u l=0.4u
X38 S GN DN B sg13_lv_nmos ad=55.5f pd=0.74u as=55.5f ps=0.74u w=0.15u l=0.4u
X39 S S S B sg13_lv_nmos ad=55.5f pd=0.74u as=0 ps=0 w=0.15u l=0.4u
X40 DP GP S B sg13_lv_nmos ad=55.5f pd=0.74u as=55.5f ps=0.74u w=0.15u l=0.4u
X41 S S S B sg13_lv_nmos ad=55.5f pd=0.74u as=0 ps=0 w=0.15u l=0.4u
X42 S S S B sg13_lv_nmos ad=55.5f pd=0.74u as=0 ps=0 w=0.15u l=0.4u
X43 DP GP S B sg13_lv_nmos ad=55.5f pd=0.74u as=55.5f ps=0.74u w=0.15u l=0.4u
X44 DN GN S B sg13_lv_nmos ad=55.5f pd=0.74u as=55.5f ps=0.74u w=0.15u l=0.4u
X45 S GP DP B sg13_lv_nmos ad=55.5f pd=0.74u as=55.5f ps=0.74u w=0.15u l=0.4u
X46 S GN DN B sg13_lv_nmos ad=55.5f pd=0.74u as=55.5f ps=0.74u w=0.15u l=0.4u
X47 S S S B sg13_lv_nmos ad=55.5f pd=0.74u as=0 ps=0 w=0.15u l=0.4u
X48 DN GN S B sg13_lv_nmos ad=55.5f pd=0.74u as=55.5f ps=0.74u w=0.15u l=0.4u
X49 S S S B sg13_lv_nmos ad=55.5f pd=0.74u as=0 ps=0 w=0.15u l=0.4u
X50 S S S B sg13_lv_nmos ad=55.5f pd=0.74u as=0 ps=0 w=0.15u l=0.4u
X51 S S S B sg13_lv_nmos ad=55.5f pd=0.74u as=0 ps=0 w=0.15u l=0.4u
X52 S GP DP B sg13_lv_nmos ad=55.5f pd=0.74u as=55.5f ps=0.74u w=0.15u l=0.4u
X53 S GN DN B sg13_lv_nmos ad=55.5f pd=0.74u as=55.5f ps=0.74u w=0.15u l=0.4u
X54 S S S B sg13_lv_nmos ad=0.1005p pd=1.34u as=0 ps=0 w=0.15u l=0.4u
X55 S S S B sg13_lv_nmos ad=55.5f pd=0.74u as=0 ps=0 w=0.15u l=0.4u
X56 S S S B sg13_lv_nmos ad=55.5f pd=0.74u as=0 ps=0 w=0.15u l=0.4u
X57 DP GP S B sg13_lv_nmos ad=55.5f pd=0.74u as=55.5f ps=0.74u w=0.15u l=0.4u
X58 S GP DP B sg13_lv_nmos ad=55.5f pd=0.74u as=55.5f ps=0.74u w=0.15u l=0.4u
X59 S GN DN B sg13_lv_nmos ad=55.5f pd=0.74u as=55.5f ps=0.74u w=0.15u l=0.4u
X60 S S S B sg13_lv_nmos ad=55.5f pd=0.74u as=0 ps=0 w=0.15u l=0.4u
X61 DN GN S B sg13_lv_nmos ad=55.5f pd=0.74u as=55.5f ps=0.74u w=0.15u l=0.4u
X62 DN GN S B sg13_lv_nmos ad=55.5f pd=0.74u as=55.5f ps=0.74u w=0.15u l=0.4u
X63 S S S B sg13_lv_nmos ad=55.5f pd=0.74u as=0 ps=0 w=0.15u l=0.4u
X64 S S S B sg13_lv_nmos ad=55.5f pd=0.74u as=0 ps=0 w=0.15u l=0.4u
X65 S S S B sg13_lv_nmos ad=55.5f pd=0.74u as=0 ps=0 w=0.15u l=0.4u
X66 S GP DP B sg13_lv_nmos ad=55.5f pd=0.74u as=55.5f ps=0.74u w=0.15u l=0.4u
X67 S S S B sg13_lv_nmos ad=55.5f pd=0.74u as=0 ps=0 w=0.15u l=0.4u
X68 S GN DN B sg13_lv_nmos ad=55.5f pd=0.74u as=55.5f ps=0.74u w=0.15u l=0.4u
X69 DP GP S B sg13_lv_nmos ad=55.5f pd=0.74u as=55.5f ps=0.74u w=0.15u l=0.4u
X70 S GN DN B sg13_lv_nmos ad=55.5f pd=0.74u as=55.5f ps=0.74u w=0.15u l=0.4u
X71 S S S B sg13_lv_nmos ad=55.5f pd=0.74u as=0 ps=0 w=0.15u l=0.4u
X72 DP GP S B sg13_lv_nmos ad=55.5f pd=0.74u as=55.5f ps=0.74u w=0.15u l=0.4u
X73 S S S B sg13_lv_nmos ad=55.5f pd=0.74u as=0 ps=0 w=0.15u l=0.4u
X74 S S S B sg13_lv_nmos ad=55.5f pd=0.74u as=0 ps=0 w=0.15u l=0.4u
X75 DN GN S B sg13_lv_nmos ad=55.5f pd=0.74u as=55.5f ps=0.74u w=0.15u l=0.4u
X76 DN GN S B sg13_lv_nmos ad=55.5f pd=0.74u as=55.5f ps=0.74u w=0.15u l=0.4u
X77 S S S B sg13_lv_nmos ad=55.5f pd=0.74u as=0 ps=0 w=0.15u l=0.4u
X78 S GP DP B sg13_lv_nmos ad=55.5f pd=0.74u as=55.5f ps=0.74u w=0.15u l=0.4u
X79 S S S B sg13_lv_nmos ad=55.5f pd=0.74u as=0 ps=0 w=0.15u l=0.4u
X80 DN GN S B sg13_lv_nmos ad=55.5f pd=0.74u as=55.5f ps=0.74u w=0.15u l=0.4u
X81 S S S B sg13_lv_nmos ad=55.5f pd=0.74u as=0 ps=0 w=0.15u l=0.4u
X82 S S S B sg13_lv_nmos ad=55.5f pd=0.74u as=0 ps=0 w=0.15u l=0.4u
X83 S S S B sg13_lv_nmos ad=55.5f pd=0.74u as=0 ps=0 w=0.15u l=0.4u
X84 S GN DN B sg13_lv_nmos ad=55.5f pd=0.74u as=55.5f ps=0.74u w=0.15u l=0.4u
X85 S S S B sg13_lv_nmos ad=55.5f pd=0.74u as=0 ps=0 w=0.15u l=0.4u
X86 S S S B sg13_lv_nmos ad=55.5f pd=0.74u as=0 ps=0 w=0.15u l=0.4u
X87 S S S B sg13_lv_nmos ad=55.5f pd=0.74u as=0 ps=0 w=0.15u l=0.4u
X88 S S S B sg13_lv_nmos ad=55.5f pd=0.74u as=0 ps=0 w=0.15u l=0.4u
X89 DN GN S B sg13_lv_nmos ad=55.5f pd=0.74u as=55.5f ps=0.74u w=0.15u l=0.4u
X90 S GP DP B sg13_lv_nmos ad=55.5f pd=0.74u as=55.5f ps=0.74u w=0.15u l=0.4u
X91 S S S B sg13_lv_nmos ad=55.5f pd=0.74u as=0 ps=0 w=0.15u l=0.4u
X92 S GN DN B sg13_lv_nmos ad=55.5f pd=0.74u as=55.5f ps=0.74u w=0.15u l=0.4u
X93 S S S B sg13_lv_nmos ad=55.5f pd=0.74u as=0 ps=0 w=0.15u l=0.4u
X94 S S S B sg13_lv_nmos ad=55.5f pd=0.74u as=0 ps=0 w=0.15u l=0.4u
X95 S S S B sg13_lv_nmos ad=55.5f pd=0.74u as=0 ps=0 w=0.15u l=0.4u
X96 S S S B sg13_lv_nmos ad=55.5f pd=0.74u as=0 ps=0 w=0.15u l=0.4u
X97 S S S B sg13_lv_nmos ad=55.5f pd=0.74u as=0 ps=0 w=0.15u l=0.4u
X98 S S S B sg13_lv_nmos ad=55.5f pd=0.74u as=0 ps=0 w=0.15u l=0.4u
X99 DP GP S B sg13_lv_nmos ad=55.5f pd=0.74u as=55.5f ps=0.74u w=0.15u l=0.4u
X100 S GN DN B sg13_lv_nmos ad=55.5f pd=0.74u as=55.5f ps=0.74u w=0.15u l=0.4u
X101 DP GP S B sg13_lv_nmos ad=55.5f pd=0.74u as=55.5f ps=0.74u w=0.15u l=0.4u
X102 S S S B sg13_lv_nmos ad=55.5f pd=0.74u as=0 ps=0 w=0.15u l=0.4u
X103 S S S B sg13_lv_nmos ad=55.5f pd=0.74u as=0 ps=0 w=0.15u l=0.4u
X104 S S S B sg13_lv_nmos ad=55.5f pd=0.74u as=0 ps=0 w=0.15u l=0.4u
X105 S S S B sg13_lv_nmos ad=55.5f pd=0.74u as=0 ps=0 w=0.15u l=0.4u
X106 S S S B sg13_lv_nmos ad=55.5f pd=0.74u as=0 ps=0 w=0.15u l=0.4u
X107 S GP DP B sg13_lv_nmos ad=55.5f pd=0.74u as=55.5f ps=0.74u w=0.15u l=0.4u
X108 DN GN S B sg13_lv_nmos ad=55.5f pd=0.74u as=55.5f ps=0.74u w=0.15u l=0.4u
X109 DN GN S B sg13_lv_nmos ad=55.5f pd=0.74u as=55.5f ps=0.74u w=0.15u l=0.4u
X110 S GP DP B sg13_lv_nmos ad=55.5f pd=0.74u as=55.5f ps=0.74u w=0.15u l=0.4u
X111 S GP DP B sg13_lv_nmos ad=0.1005p pd=1.34u as=55.5f ps=0.74u w=0.15u l=0.4u
X112 S S S B sg13_lv_nmos ad=55.5f pd=0.74u as=0 ps=0 w=0.15u l=0.4u
X113 S GN DN B sg13_lv_nmos ad=55.5f pd=0.74u as=55.5f ps=0.74u w=0.15u l=0.4u
X114 S S S B sg13_lv_nmos ad=55.5f pd=0.74u as=0 ps=0 w=0.15u l=0.4u
X115 S S S B sg13_lv_nmos ad=55.5f pd=0.74u as=0 ps=0 w=0.15u l=0.4u
X116 DP GP S B sg13_lv_nmos ad=55.5f pd=0.74u as=55.5f ps=0.74u w=0.15u l=0.4u
X117 S S S B sg13_lv_nmos ad=55.5f pd=0.74u as=0 ps=0 w=0.15u l=0.4u
X118 DP GP S B sg13_lv_nmos ad=55.5f pd=0.74u as=55.5f ps=0.74u w=0.15u l=0.4u
X119 S S S B sg13_lv_nmos ad=55.5f pd=0.74u as=0 ps=0 w=0.15u l=0.4u
X120 S GN DN B sg13_lv_nmos ad=55.5f pd=0.74u as=55.5f ps=0.74u w=0.15u l=0.4u
X121 DN GN S B sg13_lv_nmos ad=55.5f pd=0.74u as=55.5f ps=0.74u w=0.15u l=0.4u
X122 S S S B sg13_lv_nmos ad=55.5f pd=0.74u as=0 ps=0 w=0.15u l=0.4u
X123 S S S B sg13_lv_nmos ad=55.5f pd=0.74u as=0 ps=0 w=0.15u l=0.4u
X124 S GP DP B sg13_lv_nmos ad=55.5f pd=0.74u as=55.5f ps=0.74u w=0.15u l=0.4u
X125 DN GN S B sg13_lv_nmos ad=55.5f pd=0.74u as=55.5f ps=0.74u w=0.15u l=0.4u
X126 S S S B sg13_lv_nmos ad=55.5f pd=0.74u as=0 ps=0 w=0.15u l=0.4u
X127 DP GP S B sg13_lv_nmos ad=55.5f pd=0.74u as=55.5f ps=0.74u w=0.15u l=0.4u
X128 S S S B sg13_lv_nmos ad=55.5f pd=0.74u as=0 ps=0 w=0.15u l=0.4u
X129 S GN DN B sg13_lv_nmos ad=55.5f pd=0.74u as=55.5f ps=0.74u w=0.15u l=0.4u
X130 S S S B sg13_lv_nmos ad=55.5f pd=0.74u as=0 ps=0 w=0.15u l=0.4u
X131 S S S B sg13_lv_nmos ad=55.5f pd=0.74u as=0 ps=0 w=0.15u l=0.4u
X132 S S S B sg13_lv_nmos ad=55.5f pd=0.74u as=0 ps=0 w=0.15u l=0.4u
X133 DN GN S B sg13_lv_nmos ad=55.5f pd=0.74u as=55.5f ps=0.74u w=0.15u l=0.4u
X134 S S S B sg13_lv_nmos ad=55.5f pd=0.74u as=0 ps=0 w=0.15u l=0.4u
X135 S S S B sg13_lv_nmos ad=55.5f pd=0.74u as=0 ps=0 w=0.15u l=0.4u
X136 S S S B sg13_lv_nmos ad=55.5f pd=0.74u as=0 ps=0 w=0.15u l=0.4u
X137 S S S B sg13_lv_nmos ad=55.5f pd=0.74u as=0 ps=0 w=0.15u l=0.4u
X138 DP GP S B sg13_lv_nmos ad=55.5f pd=0.74u as=0.1005p ps=1.34u w=0.15u l=0.4u
X139 S S S B sg13_lv_nmos ad=55.5f pd=0.74u as=0 ps=0 w=0.15u l=0.4u
X140 S S S B sg13_lv_nmos ad=55.5f pd=0.74u as=0 ps=0 w=0.15u l=0.4u
X141 S GP DP B sg13_lv_nmos ad=55.5f pd=0.74u as=55.5f ps=0.74u w=0.15u l=0.4u
X142 DN GN S B sg13_lv_nmos ad=55.5f pd=0.74u as=55.5f ps=0.74u w=0.15u l=0.4u
X143 S S S B sg13_lv_nmos ad=55.5f pd=0.74u as=0 ps=0 w=0.15u l=0.4u
X144 S S S B sg13_lv_nmos ad=55.5f pd=0.74u as=0 ps=0 w=0.15u l=0.4u
X145 S S S B sg13_lv_nmos ad=55.5f pd=0.74u as=0 ps=0 w=0.15u l=0.4u
X146 S GN DN B sg13_lv_nmos ad=55.5f pd=0.74u as=55.5f ps=0.74u w=0.15u l=0.4u
X147 DP GP S B sg13_lv_nmos ad=55.5f pd=0.74u as=55.5f ps=0.74u w=0.15u l=0.4u
X148 S S S B sg13_lv_nmos ad=55.5f pd=0.74u as=0 ps=0 w=0.15u l=0.4u
X149 S S S B sg13_lv_nmos ad=55.5f pd=0.74u as=0 ps=0 w=0.15u l=0.4u
X150 S S S B sg13_lv_nmos ad=55.5f pd=0.74u as=0 ps=0 w=0.15u l=0.4u
X151 S S S B sg13_lv_nmos ad=55.5f pd=0.74u as=0 ps=0 w=0.15u l=0.4u
X152 S GN DN B sg13_lv_nmos ad=55.5f pd=0.74u as=55.5f ps=0.74u w=0.15u l=0.4u
X153 S GP DP B sg13_lv_nmos ad=55.5f pd=0.74u as=55.5f ps=0.74u w=0.15u l=0.4u
X154 S S S B sg13_lv_nmos ad=55.5f pd=0.74u as=0 ps=0 w=0.15u l=0.4u
X155 DP GP S B sg13_lv_nmos ad=55.5f pd=0.74u as=55.5f ps=0.74u w=0.15u l=0.4u
X156 S S S B sg13_lv_nmos ad=55.5f pd=0.74u as=0 ps=0 w=0.15u l=0.4u
X157 S GN DN B sg13_lv_nmos ad=55.5f pd=0.74u as=55.5f ps=0.74u w=0.15u l=0.4u
X158 S S S B sg13_lv_nmos ad=55.5f pd=0.74u as=0 ps=0 w=0.15u l=0.4u
X159 S GP DP B sg13_lv_nmos ad=55.5f pd=0.74u as=55.5f ps=0.74u w=0.15u l=0.4u
X160 S S S B sg13_lv_nmos ad=55.5f pd=0.74u as=0 ps=0 w=0.15u l=0.4u
X161 S S S B sg13_lv_nmos ad=55.5f pd=0.74u as=0 ps=0 w=0.15u l=0.4u
X162 S S S B sg13_lv_nmos ad=55.5f pd=0.74u as=0 ps=0 w=0.15u l=0.4u
X163 S S S B sg13_lv_nmos ad=55.5f pd=0.74u as=0 ps=0 w=0.15u l=0.4u
X164 DP GP S B sg13_lv_nmos ad=55.5f pd=0.74u as=55.5f ps=0.74u w=0.15u l=0.4u
X165 S S S B sg13_lv_nmos ad=55.5f pd=0.74u as=0 ps=0 w=0.15u l=0.4u
X166 DP GP S B sg13_lv_nmos ad=55.5f pd=0.74u as=55.5f ps=0.74u w=0.15u l=0.4u
X167 S S S B sg13_lv_nmos ad=55.5f pd=0.74u as=0 ps=0 w=0.15u l=0.4u
X168 S GN DN B sg13_lv_nmos ad=55.5f pd=0.74u as=55.5f ps=0.74u w=0.15u l=0.4u
X169 S GP DP B sg13_lv_nmos ad=55.5f pd=0.74u as=55.5f ps=0.74u w=0.15u l=0.4u
X170 S S S B sg13_lv_nmos ad=55.5f pd=0.74u as=0 ps=0 w=0.15u l=0.4u
X171 DP GP S B sg13_lv_nmos ad=55.5f pd=0.74u as=55.5f ps=0.74u w=0.15u l=0.4u
X172 S S S B sg13_lv_nmos ad=55.5f pd=0.74u as=0 ps=0 w=0.15u l=0.4u
X173 S GN DN B sg13_lv_nmos ad=55.5f pd=0.74u as=55.5f ps=0.74u w=0.15u l=0.4u
X174 DP GP S B sg13_lv_nmos ad=55.5f pd=0.74u as=55.5f ps=0.74u w=0.15u l=0.4u
X175 S GN DN B sg13_lv_nmos ad=0.1005p pd=1.34u as=55.5f ps=0.74u w=0.15u l=0.4u
X176 S S S B sg13_lv_nmos ad=55.5f pd=0.74u as=0 ps=0 w=0.15u l=0.4u
X177 S S S B sg13_lv_nmos ad=55.5f pd=0.74u as=0 ps=0 w=0.15u l=0.4u
X178 DN GN S B sg13_lv_nmos ad=55.5f pd=0.74u as=55.5f ps=0.74u w=0.15u l=0.4u
X179 DP GP S B sg13_lv_nmos ad=55.5f pd=0.74u as=55.5f ps=0.74u w=0.15u l=0.4u
X180 S GP DP B sg13_lv_nmos ad=55.5f pd=0.74u as=55.5f ps=0.74u w=0.15u l=0.4u
X181 S S S B sg13_lv_nmos ad=55.5f pd=0.74u as=0 ps=0 w=0.15u l=0.4u
X182 S S S B sg13_lv_nmos ad=55.5f pd=0.74u as=0 ps=0 w=0.15u l=0.4u
X183 S S S B sg13_lv_nmos ad=55.5f pd=0.74u as=0 ps=0 w=0.15u l=0.4u
X184 S GP DP B sg13_lv_nmos ad=55.5f pd=0.74u as=55.5f ps=0.74u w=0.15u l=0.4u
X185 DP GP S B sg13_lv_nmos ad=55.5f pd=0.74u as=55.5f ps=0.74u w=0.15u l=0.4u
X186 S S S B sg13_lv_nmos ad=55.5f pd=0.74u as=0 ps=0 w=0.15u l=0.4u
X187 S S S B sg13_lv_nmos ad=55.5f pd=0.74u as=0 ps=0 w=0.15u l=0.4u
X188 DP GP S B sg13_lv_nmos ad=55.5f pd=0.74u as=55.5f ps=0.74u w=0.15u l=0.4u
X189 S GP DP B sg13_lv_nmos ad=55.5f pd=0.74u as=55.5f ps=0.74u w=0.15u l=0.4u
X190 S S S B sg13_lv_nmos ad=55.5f pd=0.74u as=0 ps=0 w=0.15u l=0.4u
X191 DN GN S B sg13_lv_nmos ad=55.5f pd=0.74u as=55.5f ps=0.74u w=0.15u l=0.4u
X192 DN GN S B sg13_lv_nmos ad=55.5f pd=0.74u as=55.5f ps=0.74u w=0.15u l=0.4u
X193 DP GP S B sg13_lv_nmos ad=55.5f pd=0.74u as=55.5f ps=0.74u w=0.15u l=0.4u
X194 DP GP S B sg13_lv_nmos ad=55.5f pd=0.74u as=55.5f ps=0.74u w=0.15u l=0.4u
X195 S S S B sg13_lv_nmos ad=55.5f pd=0.74u as=0 ps=0 w=0.15u l=0.4u
X196 S GN DN B sg13_lv_nmos ad=55.5f pd=0.74u as=55.5f ps=0.74u w=0.15u l=0.4u
X197 S S S B sg13_lv_nmos ad=55.5f pd=0.74u as=0 ps=0 w=0.15u l=0.4u
X198 S GP DP B sg13_lv_nmos ad=55.5f pd=0.74u as=55.5f ps=0.74u w=0.15u l=0.4u
X199 DN GN S B sg13_lv_nmos ad=55.5f pd=0.74u as=55.5f ps=0.74u w=0.15u l=0.4u
.ends simplediffpair_l0p400_wf0p150_nf50_flat
